* HSPICE 방언 합성 덱 - E1 전용 픽스처
*
* 생산 HSPICE 덱은 이 저장소에 없다. 이 파일은 그 대역이며,
* E1이 다루기로 한 방언 항목만 담는다: 중첩 정의, $ 주석, .macro/.eom,
* 전역/서브회로 .param, 인스턴스 오버라이드, 그리고 의도적으로 해소
* 불가능한 값 하나. 실제 덱에는 여기 없는 구문이 있을 수 있다.
.param wn=4
.param wp='wn*2'

.subckt CORE a b W=10
M1 a b 0 0 nch W='W*2' L=1 $ 서브회로 기본값을 참조
M2 a b 0 0 nch W=wp L=1 ; 전역을 참조
M3 a b 0 0 nch W='sqrt(wn)' L=1 $ 해소 불가 - 함수
.ends

.macro WRAP p q
.subckt DEEP r s
M4 r s 0 0 nch W=wn L=1
.ends
Xd p q DEEP
M5 p q 0 0 nch W=3 L=1
.eom

Xc1 n1 n2 CORE W=20
Xw1 n3 n4 WRAP
.end
