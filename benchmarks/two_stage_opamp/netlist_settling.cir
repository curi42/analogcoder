* Two-stage CMOS op-amp (Miller-compensated), SkyWater sky130 PDK.
* Settling-time testbench: closed-loop unity-gain buffer (vout wired
* directly to vinn via the Xdut instantiation below), fed a 0.3V step at
* vinp centered near the 0.55V input common-mode point. Unlike the AC
* loop-gain testbench (which breaks feedback at AC via Lfb), this is a
* genuine closed loop - feedback factor 1, the same unity-loop-gain
* condition the AC testbench's phase_margin criterion targets. The
* OPAMP2STAGE subckt body below must stay byte-identical to netlist.cir,
* netlist_psr_plus.cir, and netlist_psr_minus.cir - tuning changes are
* applied to all four files independently and rely on that.
* Device geometry below is in microns. pdk_corner.inc sets the same option,
* but it is declared here too because the tooling that reads this file (the
* tuner's area gate) parses the netlist text only and never follows includes -
* without this line every W/L reads as tens of METRES and the area gate's size
* tiers silently collapse into their unbounded fallback.
.option scale=1.0u
.include "pdk_corner.inc"

.subckt OPAMP2STAGE vinp vinn vout vdd vss
Xp3 pbias pbias vdd vdd sky130_fd_pr__pfet_01v8 L=0.5 W=2
Xp4 nbias pbias vdd vdd sky130_fd_pr__pfet_01v8 L=0.5 W=2
Xn1 pbias nbias vss vss sky130_fd_pr__nfet_01v8 L=0.5 W=2
Xn2 nbias nbias degn vss sky130_fd_pr__nfet_01v8 L=0.5 W=8
Rdeg degn vss 20k
Rstart vdd nbias 3Meg

X1   n1   vinn tail vdd sky130_fd_pr__pfet_01v8 L=0.5 W=8
X2   outA vinp tail vdd sky130_fd_pr__pfet_01v8 L=0.5 W=8
X3   n1   n1   vss vss sky130_fd_pr__nfet_01v8 L=0.5 W=4
X4   outA n1   vss vss sky130_fd_pr__nfet_01v8 L=0.5 W=4
X5   tail pbias vdd vdd sky130_fd_pr__pfet_01v8 L=0.5 W=15

X6   vout outA vss vss sky130_fd_pr__nfet_01v8 L=0.5 W=8
X7   vout pbias vdd vdd sky130_fd_pr__pfet_01v8 L=0.5 W=30

Xcc outA vout sky130_fd_pr__cap_mim_m3_1 w=12.05 l=12.05 mf=1
Xca outA 0    sky130_fd_pr__cap_mim_m3_1 w=6.88 l=6.88 mf=1
.ends OPAMP2STAGE

Vdd vdd 0 DC 1.8
Vss vss 0 DC 0

Vinp vinp 0 PULSE(0.4 0.7 1u 1n 1n 10u 20u)
Xdut vinp vout vout vdd vss OPAMP2STAGE
Cload vout 0 2p
.end
