* Two-stage CMOS op-amp (Miller-compensated), SkyWater sky130 PDK.
* PSR+ testbench: AC=1 injected on Vdd, no input stimulus, same AC loop-break
* (Lfb) topology as the main AC testbench so the amp sees the same AC bias
* environment. Reading vdb(vout) with this topology gives supply-to-output
* gain directly. The OPAMP2STAGE subckt body below must stay byte-identical
* to netlist.cir, netlist_psr_minus.cir, and netlist_settling.cir - tuning
* changes are applied to all four files independently and rely on that.
.include "pdk_corner.inc"

.subckt OPAMP2STAGE vinp vinn vout vdd vss
Xp3 pbias pbias vdd vdd sky130_fd_pr__pfet_01v8 L=0.5 W=2
Xp4 nbias pbias vdd vdd sky130_fd_pr__pfet_01v8 L=0.5 W=2
Xn1 pbias nbias vss vss sky130_fd_pr__nfet_01v8 L=0.5 W=2
Xn2 nbias nbias degn vss sky130_fd_pr__nfet_01v8 L=0.5 W=8
Rdeg degn vss 20k
Rstart vdd nbias 3Meg

X1   n1   vinn tail vdd sky130_fd_pr__pfet_01v8 L=0.5 W=8
X2   outA vinp tail vdd sky130_fd_pr__pfet_01v8 L=0.5 W=8
X3   n1   n1   vss vss sky130_fd_pr__nfet_01v8 L=0.5 W=4
X4   outA n1   vss vss sky130_fd_pr__nfet_01v8 L=0.5 W=4
X5   tail pbias vdd vdd sky130_fd_pr__pfet_01v8 L=0.5 W=15

X6   vout outA vss vss sky130_fd_pr__nfet_01v8 L=0.5 W=8
X7   vout pbias vdd vdd sky130_fd_pr__pfet_01v8 L=0.5 W=30

Xcc outA vout sky130_fd_pr__cap_mim_m3_1 w=12.05 l=12.05 mf=1
Xca outA 0    sky130_fd_pr__cap_mim_m3_1 w=6.88 l=6.88 mf=1
.ends OPAMP2STAGE

Vdd vdd 0 DC 1.8 AC 1
Vss vss 0 DC 0

Vinp vinp 0 DC 0.55
Lfb vout vinn 1e6
Cin vstim vinn 1
Vstim vstim 0 DC 0

Xdut vinp vinn vout vdd vss OPAMP2STAGE
Cload vout 0 2p
.end
