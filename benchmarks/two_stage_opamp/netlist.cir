* Two-stage CMOS op-amp (Miller-compensated), generic level-1 devices.
* AC loop-gain testbench: Lfb blocks the DC feedback path at AC (closes the
* loop for DC biasing only), Cin injects the AC stimulus into the inverting
* input. Reading vdb(vout)/vp(vout) with this topology gives loop gain and
* loop phase directly - phase starts near 180 degrees at DC (stable negative
* feedback) and phase margin is the phase value at the frequency where the
* loop gain crosses 0 dB.
.model NMOSG NMOS (LEVEL=1 VTO=0.7 KP=120u LAMBDA=0.02)
.model PMOSG PMOS (LEVEL=1 VTO=-0.7 KP=40u LAMBDA=0.02)

.subckt OPAMP2STAGE vinp vinn vout vdd vss
Iref nb1 vdd 100u
M9 nb1 nb1 vdd vdd PMOSG W=20u L=1u

M1 n1   vinn tail vdd PMOSG W=40u L=1u
M2 outA vinp tail vdd PMOSG W=40u L=1u

M3 n1   n1   vss vss NMOSG W=20u L=1u
M4 outA n1   vss vss NMOSG W=20u L=1u

M5 tail nb1 vdd vdd PMOSG W=40u L=1u

M6 vout outA vss vss NMOSG W=40u L=1u
M7 vout nb1  vdd vdd PMOSG W=60u L=1u

Cc outA vout 2p
Ca outA 0 0.3p
.ends OPAMP2STAGE

Vdd vdd 0 DC 2.5
Vss vss 0 DC -2.5

Vinp vinp 0 DC 0
Lfb vout vinn 1e6
Cin vstim vinn 1
Vstim vstim 0 DC 0 AC 1

Xdut vinp vinn vout vdd vss OPAMP2STAGE
Cload vout 0 2p
.end
